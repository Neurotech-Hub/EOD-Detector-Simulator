* INA333 sanity bench (TI macromodel) — EOD differential pulse input
* Stage: 00_sanity_ina333

.include "../../models/ina333_ti.lib"

.param RGVAL=1.0101k
.param VCM=2.5

* Power supply (single 5 V)
Vsupply VDD 0 5
Vref REF 0 {VCM}

* Differential input from Python-generated waveform file (filesource XSPICE)
Ain %v[in_p in_n] diff_src
.model diff_src filesource (
+ file="input_diff.txt"
+ amploffset=[0 0]
+ amplscale=[1 1]
+ timeoffset=0
+ timescale=1
+ timerelative=false
+ amplstep=false
+ )

* Gain-setting resistor between RG pins (TI pin names RG+ RG-)
Rgain RGp RGn {RGVAL}

* TI INA333: IN+ IN- VCC VEE OUT REF RG+ RG-
XU1 in_p in_n VDD 0 out REF RGp RGn INA333

* High-impedance load on output
Rload out REF 1Meg

* Transient analysis — match Python sample_us via TSTEP
.param TSTEP=10u
.param TSTOP=100m
.tran {TSTEP} {TSTOP}

* Save probe nodes for Python parsing
.save v(in_p) v(in_n) v(out) v(ref)

.end
