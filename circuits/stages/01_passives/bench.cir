* Stage 01 — input passives (electrode coupling + INA bias network)
* Stage: 01_passives

.include "../includes/power.inc"
.include "../includes/eod_passives.inc"
.include "../includes/eod_stimulus.inc"

.param VDD=3.3
.param VREF=1.65
.param C_COUPLE=4.7n
.param R_SERIES=100k
.param R_VREF=10Meg
.param R_DIFF=1Meg
.param C_DIFF=330p
.param R_ELEC_A=1m
.param R_ELEC_B=1m
.param TSTEP=1u
.param TSTOP=100m

.tran {TSTEP} {TSTOP}
.save v(src_a) v(src_b) v(elec_a) v(elec_b) v(ina_p) v(ina_n) v(vref)

.end
